<dec f='ffmpeg/libswresample/swresample_internal.h' l='135' type='int'/>
<offset>93184</offset>
<doc f='ffmpeg/libswresample/swresample_internal.h' l='135'>/**&lt; soxr: if 1 then passband rolloff will be none (Chebyshev) &amp; irrational ratio approximation precision will be higher */</doc>
<use f='ffmpeg/libswresample/swresample.c' l='275' u='r' c='swr_init'/>
